ADE simulation setup
Run mode: Single Run, Sweeps and Corners
Tests:
  ESE6680_Project3:Proj3_rampTest_ddecode:1: ESE6680_Project3/Proj3_rampTest_ddecode/schematic, simulator spectre
