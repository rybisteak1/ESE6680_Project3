ADE simulation setup
Test ESE6680_Project3:Full_Adder_Test:1: ESE6680_Project3/Full_Adder_Test/schematic, simulator spectre
  Models: /apps/design_kits/ncsu-cdk-1.6.0.beta/models/spectre/nom/ami06N.m, /apps/design_kits/ncsu-cdk-1.6.0.beta/models/spectre/nom/ami06P.m
  Temperature: 27
Run mode: Single Run, Sweeps and Corners
