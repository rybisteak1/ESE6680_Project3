ADE simulation setup
Run mode: Single Run, Sweeps and Corners
Tests:
  ESE6680_Project3:Half_Adder_Test:1: ESE6680_Project3/Half_Adder_Test/schematic, simulator spectre
